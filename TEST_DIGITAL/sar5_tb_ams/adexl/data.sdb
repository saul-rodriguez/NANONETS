ADE simulation setup
Run mode: Single Run, Sweeps and Corners
Tests:
  TEST_DIGITAL:sar5_tb_ams:1: TEST_DIGITAL/sar5_tb_ams/config, simulator ams
