ADE simulation setup
Run mode: Single Run, Sweeps and Corners
Tests:
  SENSOR_SWITCH:sensor_switch_tb:1: SENSOR_SWITCH/sensor_switch_tb/config, simulator ams
Global variables:
  A0 = 0
  A1 = 0
  A2 = 0
  A3 = 0
  A4 = 0
  IDC = 1u
