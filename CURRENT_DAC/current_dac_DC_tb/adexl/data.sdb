ADE simulation setup
Run mode: Single Run, Sweeps and Corners
Tests:
  CURRENT_DAC:current_dac_DC_tb:1: CURRENT_DAC/current_dac_DC_tb/config, simulator ams
Global variables:
  A0 = 0
  A1 = 1.8
  A2 = 0
  A3 = 1.8
