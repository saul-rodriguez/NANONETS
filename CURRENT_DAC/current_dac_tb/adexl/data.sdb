ADE simulation setup
Run mode: Single Run, Sweeps and Corners
Tests:
  CURRENT_DAC:current_dac_tb:1: CURRENT_DAC/current_dac_tb/config, simulator ams
Global variables:
  T = 200u
