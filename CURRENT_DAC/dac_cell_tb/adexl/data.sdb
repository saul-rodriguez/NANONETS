ADE simulation setup
Run mode: Single Run, Sweeps and Corners
Tests:
  CURRENT_DAC:dac_cell_tb:1: CURRENT_DAC/dac_cell_tb/schematic, simulator spectre
    Outputs: IS("/I0/A0"); IS("/I0/A1"); IS("/I0/A2"); IS("/I0/A3"); IS("/I7/A0"); IS("/I7/A1"); IS("/I7/A2"); IS("/I7/A3"); IS("/I9/A0"); IS("/I9/A1"); IS("/I9/A2"); IS("/I9/A3")
Global variables:
  IDC = 2u
