design( "CHARACTERIZATION" "FT" "schematic")
modelFile(
    '("$AMS_DIR/spectre/h18/soac/mcparams.scs" "")
    '("$AMS_DIR/spectre/h18/soac/design.scs" "noitm")
    '("$AMS_DIR/spectre/h18/soac/res.scs" "restm")
    '("$AMS_DIR/spectre/h18/soac/cap.scs" "captm")
    '("$AMS_DIR/spectre/h18/soac/bip.scs" "biptm")
    '("$AMS_DIR/spectre/h18/soac/esddi.scs" "esdditm")
    '("$AMS_DIR/spectre/h18/soac/cmos53.scs" "cmostm")
)
analysis('ac ?start "10"  ?stop "100G"  ?dec "10"  )
desVar(	  "IDC" 0.001	)
desVar(	  "VDS" 0.5	)
desVar(	  "L" 1.8e-07	)
desVar(	  "W" 6.24e-06	)
envOption(
	'analysisOrder  list("dc" "ac")
)
save( 'i "/TN0/D" )
temp( 27 )
