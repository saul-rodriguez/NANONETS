ADE simulation setup
Run mode: Single Run, Sweeps and Corners
Tests:
  CHARACTERIZATION:DCBIAS5P:1: CHARACTERIZATION/DCBIAS5P/schematic, simulator spectre
    Outputs: IDC("/TN1/S")
Global variables:
  L = 1u
  VDS = 1
  VGS = 1
  W = 10u
Corners:
  model folders: /afs/ict.kth.se/proj/ektlab/PDK/AMS/spectre/h18/soac
  every corner: /afs/ict.kth.se/proj/ektlab/PDK/AMS/spectre/h18/soac/design.scs[noitm], /afs/ict.kth.se/proj/ektlab/PDK/AMS/spectre/h18/soac/esddi.scs[esdditm], /afs/ict.kth.se/proj/ektlab/PDK/AMS/spectre/h18/soac/bip.scs[biptm]
  corner_0: temperature=27; cap.scs[capwp], res.scs[reswp], cmos53.scs[cmosfff]
  corner_1 (off): temperature=27; cap.scs[capws], res.scs[reswp], cmos53.scs[cmosfff]
  corner_2 (off): temperature=27; cap.scs[capwp], res.scs[resws], cmos53.scs[cmosfff]
  corner_3 (off): temperature=27; cap.scs[capws], res.scs[resws], cmos53.scs[cmosfff]
  corner_4 (off): temperature=27; cap.scs[capwp], res.scs[reswp], cmos53.scs[cmosssf]
  corner_5 (off): temperature=27; cap.scs[capws], res.scs[reswp], cmos53.scs[cmosssf]
  corner_6 (off): temperature=27; cap.scs[capwp], res.scs[resws], cmos53.scs[cmosssf]
  corner_7 (off): temperature=27; cap.scs[capws], res.scs[resws], cmos53.scs[cmosssf]
  corner_8 (off): temperature=27; cap.scs[capwp], res.scs[reswp], cmos53.scs[cmoswo]
  corner_9 (off): temperature=27; cap.scs[capws], res.scs[reswp], cmos53.scs[cmoswo]
  corner_10 (off): temperature=27; cap.scs[capwp], res.scs[resws], cmos53.scs[cmoswo]
  corner_11 (off): temperature=27; cap.scs[capws], res.scs[resws], cmos53.scs[cmoswo]
  corner_12 (off): temperature=27; cap.scs[capwp], res.scs[reswp], cmos53.scs[cmoswz]
  corner_13 (off): temperature=27; cap.scs[capws], res.scs[reswp], cmos53.scs[cmoswz]
  corner_14 (off): temperature=27; cap.scs[capwp], res.scs[resws], cmos53.scs[cmoswz]
  corner_15 (off): temperature=27; cap.scs[capws], res.scs[resws], cmos53.scs[cmoswz]
