ADE simulation setup
Run mode: Single Run, Sweeps and Corners
Tests:
  CHARACTERIZATION:DCBIAS:1: CHARACTERIZATION/DCBIAS/schematic, simulator spectre
Global variables:
  L = 180n
  W = 10u/8
  VDS = 1
  VGS = {From/To}Linear:0:0.1:1{From/To}
Corners:
  model folders: /afs/ict.kth.se/proj/ektlab/PDK/AMS411/spectre/c18
  Fast (off): design.scs[noitm], res.scs[restm], cap.scs[captm], bip.scs[biptm], esddi.scs[esdditm], cmos53.scs[cmoswp]
  Slow: design.scs[noitm], res.scs[restm], cap.scs[captm], bip.scs[biptm], esddi.scs[esdditm], cmos53.scs[cmosws]
