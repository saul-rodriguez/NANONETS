ADE simulation setup
Run mode: Single Run, Sweeps and Corners
Tests:
  SPC:config_stimulus_tb:1: SPC/config_stimulus_tb/config, simulator ams
