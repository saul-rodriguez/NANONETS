ADE simulation setup
Run mode: Single Run, Sweeps and Corners
Tests:
  FE_CONCEPT:pmos_test:1 (off): FE_CONCEPT/pmos_test/config, simulator spectre
    Outputs: VIN; VOUT
  FE_CONCEPT:pmos_test:1:1: FE_CONCEPT/pmos_test/config, simulator spectre
    Outputs: VIN; VOUT
Global variables:
  IPULSE = IT/5
  IT = {Inclusion List}.1u{Inclusion List}{From/To}Decade:1n:3:10u{From/To}
