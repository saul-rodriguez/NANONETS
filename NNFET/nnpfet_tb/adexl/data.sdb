ADE simulation setup
Run mode: Single Run, Sweeps and Corners
Tests:
  NNFET:nnpfet_tb:1: NNFET/nnpfet_tb/config, simulator spectre
    Outputs: IS("/I0/D")
Global variables:
  VD = 1
  VG = 0.0:0.05:1.8
