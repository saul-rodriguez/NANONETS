//Verilog-AMS HDL for "DIG_CUR_DEC", "alfa" "verilogams"

`include "constants.vams"
`include "disciplines.vams"
`timescale 1 ns/ 1ps

module alfa ( out );

output  [3:0] out;

  reg [3:0]out;

initial begin
	out = 0;
	#10 out = out + 1;
	#10 out = out + 1;
	#10 out = out + 1;
	#10 out = out + 1;
	#10 out = out + 1;
	#10 out = out + 1;
	#10 out = out + 1;
	#10 out = out + 1;

	#10 out = out + 1;
	#10 out = out + 1;
	#10 out = out + 1;
	#10 out = out + 1;
	#10 out = out + 1;
	#10 out = out + 1;
	#10 out = out + 1;
	#10 out = out + 1;

	#10 out = out + 1;
	#10 out = out + 1;
	#10 out = out + 1;
	#10 out = out + 1;
	#10 out = out + 1;
	#10 out = out + 1;
	#10 out = out + 1;
	#10 out = out + 1;

end

endmodule
