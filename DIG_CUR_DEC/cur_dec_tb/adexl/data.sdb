ADE simulation setup
Run mode: Single Run, Sweeps and Corners
Tests:
  DIG_CUR_DEC:cur_dec_tb:1: DIG_CUR_DEC/cur_dec_tb/config, simulator ams
