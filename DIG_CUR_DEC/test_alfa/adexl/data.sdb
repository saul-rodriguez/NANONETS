ADE simulation setup
Run mode: Single Run, Sweeps and Corners
Tests:
  DIG_CUR_DEC:test_alfa:1: DIG_CUR_DEC/test_alfa/config, simulator ams
