ADE simulation setup
Run mode: Single Run, Sweeps and Corners
Tests:
  CHARACTERIZATION:NOISE:1: CHARACTERIZATION/NOISE/schematic, simulator spectre
  CHARACTERIZATION:NOISE:2: CHARACTERIZATION/NOISE/schematic, simulator spectre
Global variables:
  IDC = 1m
  L = 180n
  VDS = 1
  W = 10u
