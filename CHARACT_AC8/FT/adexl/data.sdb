ADE simulation setup
Run mode: Single Run, Sweeps and Corners
Tests:
  CHARACT_AC8:FT:1: CHARACT_AC8/FT/schematic, simulator spectre
    Outputs: Ft; gm; gm_id
Global variables:
  IDC = {From/To}Decade:1u:10:10m{From/To}
  L = 0.18u
  VDS = 1
  W = 10u
