ADE simulation setup
Run mode: Single Run, Sweeps and Corners
Tests:
  TEST_IO_RING:tb_top:1: TEST_IO_RING/tb_top/config, simulator ams
