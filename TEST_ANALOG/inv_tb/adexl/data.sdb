ADE simulation setup
Run mode: Single Run, Sweeps and Corners
Tests:
  TEST_ANALOG:inv_tb:1: TEST_ANALOG/inv_tb/config, simulator spectre
    Outputs: value(VT("/out") 7.06e-09)
Corners (all switched off):
  model folders: /pkg/AMS414/spectre/ac18
  every corner: /pkg/AMS414/spectre/ac18/processOption.scs, /pkg/AMS414/spectre/ac18/design.scs[noitm], /pkg/AMS414/spectre/ac18/res.scs[restm], /pkg/AMS414/spectre/ac18/cap.scs[captm], /pkg/AMS414/spectre/ac18/bip.scs[biptm], /pkg/AMS414/spectre/ac18/esddiode.scs[esddiodetm], /pkg/AMS414/spectre/ac18/cmosm.scs[cmosmtm]
  C0: cmos.scs[cmostm]
  C1_0: cmos.scs[cmostm]
  C1_1: cmos.scs[cmoswp]
  C1_2: cmos.scs[cmosws]
