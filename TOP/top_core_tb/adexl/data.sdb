ADE simulation setup
Run mode: Single Run, Sweeps and Corners
Tests:
  TOP:top_core_tb:1: TOP/top_core_tb/config, simulator ams
    Outputs: Vout; Iout; Vtest
