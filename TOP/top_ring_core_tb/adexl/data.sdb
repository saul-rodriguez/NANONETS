ADE simulation setup
Run mode: Single Run, Sweeps and Corners
Tests:
  TOP:top_ring_core_tb:1 (off): TOP/top_ring_core_tb/config_sch, simulator ams
    Outputs: I1; sample(IT("/I0/I1/I6/CUR_OUT") 0 0.02 "linear" 0.002); I4; Vout1; Vout2
  TOP:top_ring_core_tb:2: TOP/top_ring_core_tb/config_dig_cmos_sch__par_ana, simulator ams
    Outputs: I1; I4; Vout1; Vout2
