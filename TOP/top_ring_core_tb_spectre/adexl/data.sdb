ADE simulation setup
Run mode: Single Run, Sweeps and Corners
Tests:
  TOP:top_ring_core_tb_spectre:1: TOP/top_ring_core_tb_spectre/config, simulator spectre
