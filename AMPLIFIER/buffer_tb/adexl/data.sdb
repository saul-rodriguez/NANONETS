ADE simulation setup
Run mode: Monte Carlo Sampling
Tests:
  AMPLIFIER:buffer_tb:1: AMPLIFIER/buffer_tb/config, simulator spectre
    Outputs: dB20(VF("/VSAM")); dB20(VF("/VOUT")); VDC("/VOUT")
  AMPLIFIER:buffer_tb:1:1 (off): AMPLIFIER/buffer_tb/config, simulator spectre
Global variables:
  CL = 1p
  PS_AC = 1
  RL = 1M
  VDC = 0.9
  VIN_AC = 0
  VPULSE = 10m
  Vsupply = 1.8
Corners:
  model folders: /pkg/AMS414/spectre/ac18
  C0 (off): temperature=0 85; Vsupply=1.62 1.98; processOption.scs, design.scs[noitm], res.scs[reswp resws], cap.scs[capwp capws], bip.scs[biptm], esddiode.scs[esddiodetm], cmos.scs[cmoswo cmoswz cmoswp cmosws], cmosm.scs[cmosmtm]
  C1 (off): Vsupply=1.62 1.98; processOption.scs, design.scs[noitm], res.scs[restm], cap.scs[captm], bip.scs[biptm], esddiode.scs[esddiodetm], cmos.scs[cmoswo cmoswz cmoswp cmosws], cmosm.scs[cmosmtm]
Monte Carlo Sampling options: mcmethod=all, mcnumpoints=200
